`include "disciplines.vams"

module bus_nonconstant_index(p, n);
    inout p, n;
    electrical p, n;
    electrical [3:0] bus;
    real i;
    analog begin
        i = 2;
        V(bus[i], n) <+ 1.0;
    end
endmodule
