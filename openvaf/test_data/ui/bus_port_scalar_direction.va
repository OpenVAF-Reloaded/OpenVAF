`include "disciplines.vams"

module bus_port_scalar_direction(d, out);
    input d;
    output out;
    electrical [0:1] d;
    electrical out;
    analog V(out) <+ V(d[0]);
endmodule
