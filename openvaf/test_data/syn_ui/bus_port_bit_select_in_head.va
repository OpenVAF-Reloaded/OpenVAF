`include "disciplines.vams"

module bus_port_bit_select_in_head(d[0], out);
    input [0:1] d;
    output out;
    electrical [0:1] d;
    electrical out;
    analog V(out) <+ V(d[0]);
endmodule
